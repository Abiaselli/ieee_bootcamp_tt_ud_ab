// Izhikevich mixed-signal neuron, generated from uploaded zvndigital.cir topology
// Device sizes: SKY130 ratio-scaled
// Source topology: user-uploaded LTspice netlist zvndigital.cir
// Paper sizes: Srinivasan & Cowan 2022 Fig. 1 component table
simulator lang=spectre
global 0

// EDIT THIS PATH for your Cadence/Open_PDKS install.
// In ADE, it is often better to add the sky130 model library through Setup -> Model Libraries.
// include "$PDK_ROOT/sky130A/libs.tech/ngspice/sky130.lib.spice" section=tt

// Ports:
//   V      = membrane node and post-synaptic current/voltage injection node
//   U      = recovery-variable node
//   VC     = V reset bias
//   VD     = U increment/reset bias
//   ACK    = active-high acknowledge/reset input
//   REQ    = active-low request/spike output
//   VDD    = analog/digital high rail for this macro
//   VGND   = local ground/reference bias; can be tied to 0 or biased deliberately
subckt izh_sky130_zvndigital_papersize V U VC VD ACK REQ VDD VGND
  Cv (V VGND) capacitor c=20f
  Cu (U VGND) capacitor c=300f
  Creq (REQ VGND) capacitor c=25f
  M1 (N001 V VGND VGND) sky130_fd_pr__nfet_01v8 w=420n l=175n
  M2 (N001 N001 VDD VDD) sky130_fd_pr__pfet_01v8 w=420n l=175n
  M3 (V N001 VDD VDD) sky130_fd_pr__pfet_01v8 w=420n l=175n
  M4 (U N001 VDD VDD) sky130_fd_pr__pfet_01v8 w=1.08333u l=150n
  M5 (V U VGND VGND) sky130_fd_pr__nfet_01v8 w=420n l=630n
  M6 (U U VGND VGND) sky130_fd_pr__nfet_01v8 w=700n l=150n
  M7 (V ACK VC VC) sky130_fd_pr__nfet_01v8 w=420n l=840n
  M8 (U N002 VD VD) sky130_fd_pr__pfet_01v8 w=1.56u l=150n
  M9 (N005 V VGND VGND) sky130_fd_pr__nfet_01v8 w=420n l=420n
  M10 (N005 V VDD VDD) sky130_fd_pr__pfet_01v8 w=1.5u l=150n
  M11 (N003 N005 VGND VGND) sky130_fd_pr__nfet_01v8 w=1.5u l=150n
  M12 (N003 N005 N004 N004) sky130_fd_pr__pfet_01v8 w=420n l=420n
  M13 (VGND N003 N006 N006) sky130_fd_pr__nfet_01v8 w=420n l=210n
  M14 (N003 N005 VGND VGND) sky130_fd_pr__nfet_01v8 w=420n l=420n
  M15 (REQ N003 VGND VGND) sky130_fd_pr__nfet_01v8 w=420n l=1.05u
  M16 (N002 ACK N006 N006) sky130_fd_pr__nfet_01v8 w=420n l=420n
  M17 (N004 ACK VDD VDD) sky130_fd_pr__pfet_01v8 w=420n l=420n
  M18 (REQ N003 VDD VDD) sky130_fd_pr__pfet_01v8 w=420n l=210n
  MX_ACK_P (N002 ACK VDD VDD) sky130_fd_pr__pfet_01v8 w=420n l=210n
ends izh_sky130_zvndigital_papersize

// Example transient testbench. Uncomment after the model include is correct.
// XN (v u vc vd ack req vdd vgnd) izh_sky130_zvndigital_papersize
// Vvdd (vdd 0) vsource dc=0.18
// Vgnd (vgnd 0) vsource dc=0
// Vvc  (vc 0) vsource dc=0.14
// Vvd  (vd 0) vsource dc=0.14
// Iin  (v vgnd) isource dc=2p
// Vack (ack 0) vsource type=pulse val0=0 val1=0.18 delay=1u rise=1n fall=1n width=1u period=20u
// tran tran stop=10m maxstep=100n
