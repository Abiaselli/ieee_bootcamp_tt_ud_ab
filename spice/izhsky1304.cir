* C:\Users\abias\Downloads\7225uddupont\izhsky1304.asc
* Generated by LTspice 26.0.1 for Windows.
Cu U N007 300f
M1 N002 N002 Vdd Vdd PMOS w=100n l=100n
M3 V N002 Vdd Vdd PMOS w=100n l=100n
M4 U N002 Vdd Vdd PMOS w=300n l=125n
M8 U N001 Vd Vd PMOS w=1.3u l=125
M10 N005 V Vdd Vdd PMOS w=1u l=100n
M13 N004 ACK Vdd Vdd PMOS w=200n l=100n
M17 N001 ACK Vdd Vdd PMOS w=100n l=100n
M18 REQ N003 Vdd Vdd PMOS w=200n l=100n
M2 N002 V N007 N007 NMOS w=2.5u l=5u
M5 V U N007 N007 NMOS w=2.5u l=2.5u
M6 U U N007 N007 NMOS w=0.5u l=2.5u
M7 V ACK Vc Vc NMOS w=100n l=100n
M9 N005 V 0 0 NMOS w=100n l=100n
M11 N003 N005 0 0 NMOS w=100n l=100n
M14 N006 N003 0 0 NMOS w=100n l=100n
M15 REQ N003 0 0 NMOS w=100n l=250n
M16 N001 ACK N006 N006 NMOS w=100n l=100n
M12 N003 N005 N004 N004 PMOS w=100n l=100n
C1 REQ 0 25f
C2 V 0 25u
.model NMOS NMOS
.model PMOS PMOS
.lib C:\Users\abias\AppData\Local\LTspice\lib\cmp\standard.mos
* U
.tran 0 6ms 0 500n
.backanno
.end
